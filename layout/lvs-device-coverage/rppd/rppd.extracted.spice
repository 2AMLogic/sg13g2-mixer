* extracted by klt extract --deck sg13g2

* cell rppd
* pin vsubs
.SUBCKT rppd vsubs
* device instance $1 r0 *1 8.239,0.094 rppd
X$1 \$6 \$11 vsubs rppd r=541.926345609 L=1.2U W=0.7U
* device instance $2 r0 *1 2.832,0.25 rppd
X$2 \$8 \$9 vsubs rppd r=396.916996047 L=0.5U W=0.5U
* device instance $3 r0 *1 5.292,0.113 rppd
X$3 \$7 \$10 vsubs rppd r=653.833992095 L=1U W=0.5U
* device instance $4 r0 *1 337.49,87.971 rppd
X$4 \$17 \$14 vsubs rppd r=6322.77366881 L=123.9U W=5.1U
* device instance $5 r0 *1 -399.015,90.011 rppd
X$5 \$19 \$21 vsubs rppd r=4102.6170256 L=73.83U W=4.69U
* device instance $6 r0 *1 -253.73,86.866 rppd
X$6 \$22 \$24 vsubs rppd r=2344.94302932 L=45.06U W=5.02U
* device instance $7 r0 *1 34.18,87.446 rppd
X$7 \$28 \$25 vsubs rppd r=2688.95620259 L=47.78U W=4.64U
* device instance $8 r0 *1 -688,89.156 rppd
X$8 \$13 \$15 vsubs rppd r=2556.02318901 L=57.3U W=5.85U
* device instance $9 r0 *1 -549.145,91.026 rppd
X$9 \$16 \$18 vsubs rppd r=13252.894688 L=85.16U W=1.67U
* device instance $10 r0 *1 -121.08,89.606 rppd
X$10 \$26 \$27 vsubs rppd r=8907.51741486 L=21.86U W=0.64U
* device instance $11 r0 *1 185.095,91.126 rppd
X$11 \$23 \$20 vsubs rppd r=9824.62064792 L=148.46U W=3.93U
* device instance $12 r0 *1 -686.85,135.566 rppd
X$12 \$30 \$31 vsubs rppd r=4510.00437778 L=88.3U W=5.1U
* device instance $13 r0 *1 -549.465,131.886 rppd
X$13 \$33 \$34 vsubs rppd r=1475.02715199 L=22.06U W=3.93U
* device instance $14 r0 *1 -399.14,134.046 rppd
X$14 \$36 \$37 vsubs rppd r=3897.73795033 L=69.38U W=4.64U
* device instance $15 r0 *1 -264.7,131.306 rppd
X$15 \$39 \$40 vsubs rppd r=4126.09326625 L=9.98U W=0.64U
* device instance $16 r0 *1 -104.07,134.451 rppd
X$16 \$42 \$43 vsubs rppd r=5766.94860035 L=111.21U W=5.02U
* device instance $17 r0 *1 31.88,135.466 rppd
X$17 \$44 \$41 vsubs rppd r=3630.34274962 L=65.3U W=4.69U
* device instance $18 r0 *1 175.855,133.596 rppd
X$18 \$38 \$35 vsubs rppd r=13347.5247596 L=85.77U W=1.67U
* device instance $19 r0 *1 338.175,132.411 rppd
X$19 \$32 \$29 vsubs rppd r=5445.9480524 L=122.39U W=5.85U
* device instance $20 r0 *1 -697.305,176.851 rppd
X$20 \$46 \$47 vsubs rppd r=2547.28609607 L=16.15U W=1.67U
* device instance $21 r0 *1 -542.63,180.006 rppd
X$21 \$49 \$50 vsubs rppd r=4546.61433851 L=87.62U W=5.02U
* device instance $22 r0 *1 -389.44,179.906 rppd
X$22 \$52 \$53 vsubs rppd r=8862.69705494 L=158.1U W=4.64U
* device instance $23 r0 *1 -253.55,178.036 rppd
X$23 \$54 \$56 vsubs rppd r=3504.83399 L=68.56U W=5.1U
* device instance $24 r0 *1 -101.195,175.746 rppd
X$24 \$57 \$59 vsubs rppd r=3434.23357153 L=77.08U W=5.85U
* device instance $25 r0 *1 46.505,176.326 rppd
X$25 \$60 \$58 vsubs rppd r=5879.87426581 L=105.93U W=4.69U
* device instance $26 r0 *1 168.215,178.891 rppd
X$26 \$55 \$51 vsubs rppd r=13330.7372291 L=32.85U W=0.64U
* device instance $27 r0 *1 321.295,178.486 rppd
X$27 \$48 \$45 vsubs rppd r=4225.63690809 L=63.7U W=3.93U
* device instance $28 r0 *1 -695.425,222.926 rppd
X$28 \$62 \$63 vsubs rppd r=7125.20972375 L=45.66U W=1.67U
* device instance $29 r0 *1 -545.355,223.331 rppd
X$29 \$65 \$66 vsubs rppd r=4493.16739589 L=67.75U W=3.93U
* device instance $30 r0 *1 -409.14,222.476 rppd
X$30 \$68 \$69 vsubs rppd r=13342.8115325 L=32.88U W=0.64U
* device instance $31 r0 *1 -254.575,221.291 rppd
X$31 \$71 \$72 vsubs rppd r=2973.14513463 L=53.43U W=4.69U
* device instance $32 r0 *1 -113.275,224.446 rppd
X$32 \$75 \$76 vsubs rppd r=2311.82919994 L=51.8U W=5.85U
* device instance $33 r0 *1 30.04,224.346 rppd
X$33 \$74 \$73 vsubs rppd r=2468.09290109 L=48.2U W=5.1U
* device instance $34 r0 *1 190.705,220.186 rppd
X$34 \$70 \$67 vsubs rppd r=5243.62688705 L=93.43U W=4.64U
* device instance $35 r0 *1 321.415,220.766 rppd
X$35 \$64 \$61 vsubs rppd r=2011.27808702 L=38.61U W=5.02U
* device instance $36 r0 *1 -676.65,265.731 rppd
X$36 \$78 \$80 vsubs rppd r=5658.31350285 L=109.11U W=5.02U
* device instance $37 r0 *1 -538.75,266.916 rppd
X$37 \$82 \$83 vsubs rppd r=5310.22180741 L=94.62U W=4.64U
* device instance $38 r0 *1 -387.41,267.771 rppd
X$38 \$85 \$86 vsubs rppd r=7504.63814198 L=147.11U W=5.1U
* device instance $39 r0 *1 -236.575,267.366 rppd
X$39 \$88 \$89 vsubs rppd r=7560.22400869 L=170.01U W=5.85U
* device instance $40 r0 *1 187.155,268.786 rppd
X$40 \$84 \$81 vsubs rppd r=10841.2365016 L=163.85U W=3.93U
* device instance $41 r0 *1 -115.015,264.626 rppd
X$41 \$90 \$92 vsubs rppd r=1210.8367871 L=21.6U W=4.69U
* device instance $42 r0 *1 26.255,268.886 rppd
X$42 \$91 \$87 vsubs rppd r=43025.4740712 L=106.63U W=0.64U
* device instance $43 r0 *1 315.645,265.206 rppd
X$43 \$79 \$77 vsubs rppd r=3768.16915096 L=24.02U W=1.67U
* device instance $44 r0 *1 -696.375,309.066 rppd
X$44 \$94 \$95 vsubs rppd r=2193.58681206 L=13.87U W=1.67U
* device instance $45 r0 *1 -541.235,310.171 rppd
X$45 \$97 \$99 vsubs rppd r=4609.42755849 L=69.51U W=3.93U
* device instance $46 r0 *1 -408.31,309.646 rppd
X$46 \$101 \$102 vsubs rppd r=9237.54837461 L=22.68U W=0.64U
* device instance $47 r0 *1 -244.815,311.356 rppd
X$47 \$103 \$105 vsubs rppd r=6944.56762186 L=125.16U W=4.69U
* device instance $48 r0 *1 -107.235,313.226 rppd
X$48 \$107 \$108 vsubs rppd r=4152.60788847 L=93.26U W=5.85U
* device instance $49 r0 *1 32.685,311.806 rppd
X$49 \$106 \$104 vsubs rppd r=2884.11326928 L=56.37U W=5.1U
* device instance $50 r0 *1 173.8,312.211 rppd
X$50 \$100 \$98 vsubs rppd r=2268.68069678 L=40.27U W=4.64U
* device instance $51 r0 *1 324.02,311.806 rppd
X$51 \$96 \$93 vsubs rppd r=3760.30315665 L=72.42U W=5.02U
* device instance $52 r0 *1 -687.07,357.676 rppd
X$52 \$110 \$111 vsubs rppd r=4494.8833397 L=86.62U W=5.02U
* device instance $53 r0 *1 -545.995,357.776 rppd
X$53 \$113 \$114 vsubs rppd r=3695.71470453 L=65.77U W=4.64U
* device instance $54 r0 *1 -397.99,354.096 rppd
X$54 \$117 \$118 vsubs rppd r=2634.09368448 L=51.46U W=5.1U
* device instance $55 r0 *1 -251.675,356.661 rppd
X$55 \$120 \$121 vsubs rppd r=3701.95898136 L=83.11U W=5.85U
* device instance $56 r0 *1 -110.135,357.776 rppd
X$56 \$123 \$124 vsubs rppd r=4719.9509268 L=84.98U W=4.69U
* device instance $57 r0 *1 24.18,354.621 rppd
X$57 \$122 \$119 vsubs rppd r=8573.46168731 L=21.03U W=0.64U
* device instance $58 r0 *1 176.855,353.516 rppd
X$58 \$116 \$115 vsubs rppd r=2415.67755849 L=36.3U W=3.93U
* device instance $59 r0 *1 317.505,357.776 rppd
X$59 \$112 \$109 vsubs rppd r=13470.0784588 L=86.56U W=1.67U
* device instance $60 r0 *1 -546.355,401.101 rppd
X$60 \$128 \$130 vsubs rppd r=16000.2693896 L=102.87U W=1.67U
* device instance $61 r0 *1 -399.14,399.061 rppd
X$61 \$133 \$134 vsubs rppd r=2982.75732183 L=53.03U W=4.64U
* device instance $62 r0 *1 -258.405,397.956 rppd
X$62 \$136 \$137 vsubs rppd r=5567.69182399 L=35.62U W=1.67U
* device instance $63 r0 *1 183.635,400.696 rppd
X$63 \$132 \$131 vsubs rppd r=5635.70901879 L=101.52U W=4.69U
* device instance $64 r0 *1 326.095,398.536 rppd
X$64 \$129 \$125 vsubs rppd r=2563.12701415 L=57.46U W=5.85U
* device instance $65 r0 *1 -692.28,400.246 rppd
X$65 \$126 \$127 vsubs rppd r=1910.40263934 L=36.66U W=5.02U
* device instance $66 r0 *1 -114.095,400.246 rppd
X$66 \$138 \$140 vsubs rppd r=3039.91536337 L=45.75U W=3.93U
* device instance $67 r0 *1 25.84,402.116 rppd
X$67 \$139 \$135 vsubs rppd r=37950.2418731 L=94.02U W=0.64U
* device instance $68 r0 *1 -681.58,442.396 rppd
X$68 \$142 \$143 vsubs rppd r=3480.39215686 L=68.08U W=5.1U
* device instance $69 r0 *1 -242.97,442.976 rppd
X$69 \$151 \$152 vsubs rppd r=5153.63931707 L=100.94U W=5.1U
* device instance $70 r0 *1 -109.11,446.556 rppd
X$70 \$154 \$155 vsubs rppd r=4457.04707265 L=87.26U W=5.1U
* device instance $71 r0 *1 35.33,444.686 rppd
X$71 \$156 \$153 vsubs rppd r=3504.83399 L=68.56U W=5.1U
* device instance $72 r0 *1 179.78,443.501 rppd
X$72 \$150 \$147 vsubs rppd r=2901.42623442 L=56.71U W=5.1U
* device instance $73 r0 *1 -529.605,442.396 rppd
X$73 \$145 \$146 vsubs rppd r=5201.01147341 L=100.27U W=5.02U
* device instance $74 r0 *1 -406.565,442.396 rppd
X$74 \$148 \$149 vsubs rppd r=2868.40781444 L=18.22U W=1.67U
* device instance $75 r0 *1 323.075,443.501 rppd
X$75 \$144 \$141 vsubs rppd r=2133.78958246 L=47.79U W=5.85U
* device instance $76 r0 *1 -687.895,487.416 rppd
X$76 \$157 \$158 vsubs rppd r=2682.47222152 L=48.18U W=4.69U
* device instance $77 r0 *1 -551.92,489.576 rppd
X$77 \$159 \$160 vsubs rppd r=27662.9353715 L=68.46U W=0.64U
* device instance $78 r0 *1 -400.915,489.981 rppd
X$78 \$161 \$162 vsubs rppd r=4493.16739589 L=67.75U W=3.93U
* device instance $79 r0 *1 -260.595,489.981 rppd
X$79 \$163 \$164 vsubs rppd r=2490.32186744 L=37.43U W=3.93U
* device instance $80 r0 *1 -112.035,489.981 rppd
X$80 \$165 \$166 vsubs rppd r=4493.16739589 L=67.75U W=3.93U
* device instance $81 r0 *1 34.18,489.981 rppd
X$81 \$167 \$168 vsubs rppd r=4124.38452803 L=73.43U W=4.64U
* device instance $82 r0 *1 179.78,491.096 rppd
X$82 \$169 \$170 vsubs rppd r=4507.96755835 L=88.26U W=5.1U
.ENDS rppd
