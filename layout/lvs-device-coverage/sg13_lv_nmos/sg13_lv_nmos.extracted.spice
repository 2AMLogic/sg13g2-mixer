* extracted by klt extract --deck sg13g2

* cell sg13_lv_nmos
* pin vsubs
.SUBCKT sg13_lv_nmos vsubs
* device instance $1 r0 *1 56.789,-33.08 nfet
M$1 \$5 \$1 \$4 vsubs nfet L=8.38U W=9.53U AS=3.2402P AD=3.2402P PS=19.74U
+ PD=19.74U
* device instance $2 r0 *1 144.499,-35.72 nfet
M$2 \$7 \$2 \$6 vsubs nfet L=0.77U W=4.25U AS=1.445P AD=1.445P PS=9.18U PD=9.18U
* device instance $3 r0 *1 190.219,-33.215 nfet
M$3 \$9 \$3 \$8 vsubs nfet L=5.03U W=9.26U AS=3.1484P AD=3.1484P PS=19.2U
+ PD=19.2U
* device instance $4 r0 *1 102.404,-34.173 nfet
M$4 \$12 \$11 \$10 vsubs nfet L=3.74U W=5.55U AS=1.887P AD=1.887P PS=11.78U
+ PD=11.78U
* device instance $5 r0 *1 233.594,-33.403 nfet
M$5 \$15 \$14 \$13 vsubs nfet L=4.6U W=7.09U AS=2.4106P AD=2.4106P PS=14.86U
+ PD=14.86U
* device instance $6 r0 *1 3.765,-1.619 nfet
M$6 \$18 \$20 \$17 vsubs nfet L=0.3U W=0.1U AS=0.097P AD=0.052P PS=1.34U
+ PD=0.74U
* device instance $7 r0 *1 4.505,-1.619 nfet
M$7 \$17 \$20 \$18 vsubs nfet L=0.3U W=0.1U AS=0.052P AD=0.052P PS=0.74U
+ PD=0.74U
* device instance $8 r0 *1 5.245,-1.619 nfet
M$8 \$18 \$20 \$17 vsubs nfet L=0.3U W=0.1U AS=0.052P AD=0.097P PS=0.74U
+ PD=1.34U
* device instance $9 r0 *1 -0.059,-1.497 nfet
M$9 \$19 \$21 \$16 vsubs nfet L=0.15U W=0.15U AS=0.1005P AD=0.0555P PS=1.34U
+ PD=0.74U
* device instance $10 r0 *1 0.531,-1.497 nfet
M$10 \$16 \$21 \$19 vsubs nfet L=0.15U W=0.15U AS=0.0555P AD=0.1005P PS=0.74U
+ PD=1.34U
* device instance $11 r0 *1 0.023,0.275 nfet
M$11 \$25 \$24 \$23 vsubs nfet L=0.13U W=0.15U AS=0.1005P AD=0.1005P PS=1.34U
+ PD=1.34U
* device instance $12 r0 *1 2.36,0.284 nfet
M$12 \$28 \$27 \$26 vsubs nfet L=0.13U W=0.2U AS=0.104P AD=0.104P PS=1.34U
+ PD=1.34U
* device instance $13 r0 *1 0.02,2.078 nfet
M$13 \$31 \$30 \$29 vsubs nfet L=0.25U W=0.2U AS=0.104P AD=0.104P PS=1.34U
+ PD=1.34U
* device instance $14 r0 *1 4.817,0.308 nfet
M$14 \$34 \$33 \$32 vsubs nfet L=0.15U W=0.2U AS=0.104P AD=0.104P PS=1.34U
+ PD=1.34U
* device instance $15 r0 *1 0.02,4.346 nfet
M$15 \$31 \$30 \$29 vsubs nfet L=0.25U W=0.2U AS=0.104P AD=0.104P PS=1.34U
+ PD=1.34U
* device instance $16 r0 *1 5.759,4.321 nfet
M$16 \$36 \$37 \$35 vsubs nfet L=0.15U W=0.15U AS=0.1005P AD=0.0555P PS=1.34U
+ PD=0.74U
* device instance $17 r0 *1 6.349,4.321 nfet
M$17 \$35 \$37 \$36 vsubs nfet L=0.15U W=0.15U AS=0.0555P AD=0.1005P PS=0.74U
+ PD=1.34U
* device instance $18 r0 *1 0.02,6.346 nfet
M$18 \$31 \$30 \$29 vsubs nfet L=0.25U W=0.2U AS=0.104P AD=0.104P PS=1.34U
+ PD=1.34U
* device instance $19 r0 *1 5.704,6.423 nfet
M$19 \$36 \$37 \$35 vsubs nfet L=0.15U W=0.15U AS=0.1005P AD=0.0555P PS=1.34U
+ PD=0.74U
* device instance $20 r0 *1 6.294,6.423 nfet
M$20 \$35 \$37 \$36 vsubs nfet L=0.15U W=0.15U AS=0.0555P AD=0.1005P PS=0.74U
+ PD=1.34U
* device instance $21 r0 *1 100.317,11.262 nfet
M$21 \$40 \$39 \$38 vsubs nfet L=3.59U W=9.26U AS=3.1484P AD=3.1484P PS=19.2U
+ PD=19.2U
* device instance $22 r0 *1 231.592,7.657 nfet
M$22 \$43 \$42 \$41 vsubs nfet L=4.6U W=2.05U AS=0.697P AD=0.697P PS=4.78U
+ PD=4.78U
* device instance $23 r0 *1 319.332,11.397 nfet
M$23 \$46 \$45 \$44 vsubs nfet L=5.74U W=9.53U AS=3.2402P AD=3.2402P PS=19.74U
+ PD=19.74U
* device instance $24 r0 *1 361.922,9.512 nfet
M$24 \$49 \$48 \$47 vsubs nfet L=3.74U W=5.76U AS=1.9584P AD=1.9584P PS=12.2U
+ PD=12.2U
* device instance $25 r0 *1 55.317,11.836 nfet
M$25 \$52 \$51 \$50 vsubs nfet L=0.77U W=9.53U AS=3.2402P AD=3.2402P PS=19.74U
+ PD=19.74U
* device instance $26 r0 *1 144.627,11.06 nfet
M$26 \$55 \$54 \$53 vsubs nfet L=5.03U W=8.29U AS=2.8186P AD=2.8186P PS=17.26U
+ PD=17.26U
* device instance $27 r0 *1 186.287,9.196 nfet
M$27 \$58 \$57 \$56 vsubs nfet L=1.17U W=4.25U AS=1.445P AD=1.445P PS=9.18U
+ PD=9.18U
* device instance $28 r0 *1 277.062,8.096 nfet
M$28 \$61 \$60 \$59 vsubs nfet L=8.38U W=2.05U AS=0.697P AD=0.697P PS=4.78U
+ PD=4.78U
* device instance $29 r0 *1 55.517,54.806 nfet
M$29 \$71 \$65 \$70 vsubs nfet L=1.17U W=8.29U AS=2.8186P AD=2.8186P PS=17.26U
+ PD=17.26U
* device instance $30 r0 *1 101.392,53.941 nfet
M$30 \$83 \$82 \$81 vsubs nfet L=5.74U W=4.25U AS=1.445P AD=1.445P PS=9.18U
+ PD=9.18U
* device instance $31 r0 *1 142.697,53.541 nfet
M$31 \$73 \$66 \$72 vsubs nfet L=1.17U W=5.76U AS=1.9584P AD=1.9584P PS=12.2U
+ PD=12.2U
* device instance $32 r0 *1 188.002,53.436 nfet
M$32 \$75 \$67 \$74 vsubs nfet L=4.6U W=5.55U AS=1.887P AD=1.887P PS=11.78U
+ PD=11.78U
* device instance $33 r0 *1 231.087,52.786 nfet
M$33 \$77 \$68 \$76 vsubs nfet L=3.59U W=4.25U AS=1.445P AD=1.445P PS=9.18U
+ PD=9.18U
* device instance $34 r0 *1 274.667,52.786 nfet
M$34 \$79 \$69 \$78 vsubs nfet L=3.59U W=4.25U AS=1.445P AD=1.445P PS=9.18U
+ PD=9.18U
* device instance $35 r0 *1 322.098,53.785 nfet
M$35 \$85 \$80 \$84 vsubs nfet L=8.38U W=4.25U AS=1.445P AD=1.445P PS=9.18U
+ PD=9.18U
* device instance $36 r0 *1 361.847,53.767 nfet
M$36 \$64 \$63 \$62 vsubs nfet L=3.59U W=7.09U AS=2.4106P AD=2.4106P PS=14.86U
+ PD=14.86U
.ENDS sg13_lv_nmos
